;; build_cdac_tb.il  v3 -- CDAC_12b full TB (idempotent, ASCII, no setof)
;; load("/home1/sf3101/pdk_analog/CADENCE_ENV/0_BARAM/build_cdac_tb.il")
;; buildCdacTB("0_BARAM" "tset_CDAC12b" "CDAC_12b" 12 10e-9 10e-9)

procedure(tbTermPt(inst tname)
  let((res)
    foreach(mt inst~>master~>terminals
      when(mt~>name==tname
        res = dbTransformPoint(centerBox(car(mt~>pins)~>fig~>bBox) inst~>transform)))
    res))

procedure(tbSetCdf(cdf prompt val)
  foreach(fld cdf~>parameters
    when(fld~>prompt==prompt fld~>value = val)))

procedure(tbPin(cv inst tname netName dx dy)
  let((pt w)
    pt = tbTermPt(inst tname)
    when(pt
      w = schCreateWire(cv "route" "full"
            list(pt list(xCoord(pt)+dx yCoord(pt)+dy)) 0.0625 0.0625 0.0)
      schCreateWireLabel(cv car(w) list(xCoord(pt)+dx yCoord(pt)+dy)
        netName "lowerCenter" "R0" "stick" 0.0625 nil))))

procedure(tbInst(cv lib cell name loc)
  dbCreateInst(cv dbOpenCellViewByType(lib cell "symbol") name loc "R0"))

procedure(buildCdacTB(tbLib tbCell dutCell @optional (Nbit 12) (Tcode 10e-9) (t_rst 10e-9))
  let((cv dut src vdd rst swo swx cdf k dly wid per)
    cv = dbOpenCellViewByType(tbLib tbCell "schematic" "schematic" "a")
    foreach(x cv~>instances dbDeleteObject(x))
    foreach(x cv~>shapes dbDeleteObject(x))
    dut = tbInst(cv tbLib dutCell "I0" list(8.0 0.0))
    tbPin(cv dut "IN<11:0>" "IN<11:0>" -1.0 0.0)
    tbPin(cv dut "VDD" "VDD" 0.0 1.0)
    tbPin(cv dut "VOUT" "VOUT" 1.0 0.5)
    tbPin(cv dut "VX" "VX" 1.0 -0.5)
    tbPin(cv dut "VSS" "VSS" 0.0 -1.0)
    for(k 0 Nbit-1
      dly = t_rst + expt(2.0 k)*Tcode
      wid = expt(2.0 k)*Tcode
      per = expt(2.0 k+1)*Tcode
      src = tbInst(cv "analogLib" "vpulse" sprintf(nil "V_IN%d" k) list(0.0 -2.0*k))
      cdf = cdfGetInstCDF(src)
      tbSetCdf(cdf "Voltage 1" "1")
      tbSetCdf(cdf "Voltage 2" "0")
      tbSetCdf(cdf "Period" sprintf(nil "%g" per))
      tbSetCdf(cdf "Delay time" sprintf(nil "%g" dly))
      tbSetCdf(cdf "Pulse width" sprintf(nil "%g" wid))
      tbSetCdf(cdf "Rise time" "10p")
      tbSetCdf(cdf "Fall time" "10p")
      tbPin(cv src "PLUS" sprintf(nil "IN<%d>" k) 0.5 0.0)
      tbPin(cv src "MINUS" "VSS" 0.0 -0.5)
    )
    vdd = tbInst(cv "analogLib" "vdc" "V_VDD" list(16.0 3.0))
    cdf = cdfGetInstCDF(vdd)
    tbSetCdf(cdf "DC voltage" "1")
    tbPin(cv vdd "PLUS" "VDD" 0.5 0.0)
    tbPin(cv vdd "MINUS" "VSS" 0.0 -0.5)
    rst = tbInst(cv "analogLib" "vpulse" "V_RST" list(16.0 0.0))
    cdf = cdfGetInstCDF(rst)
    tbSetCdf(cdf "Voltage 1" "0")
    tbSetCdf(cdf "Voltage 2" "1")
    tbSetCdf(cdf "Delay time" "0")
    tbSetCdf(cdf "Pulse width" sprintf(nil "%g" t_rst))
    tbSetCdf(cdf "Period" "1")
    tbSetCdf(cdf "Rise time" "10p")
    tbSetCdf(cdf "Fall time" "10p")
    tbPin(cv rst "PLUS" "RST" 0.5 0.0)
    tbPin(cv rst "MINUS" "VSS" 0.0 -0.5)
    swo = tbInst(cv "analogLib" "switch" "SW_O" list(13.0 3.0))
    swx = tbInst(cv "analogLib" "switch" "SW_X" list(13.0 -1.0))
    foreach(sw list(swo swx)
      cdf = cdfGetInstCDF(sw)
      tbSetCdf(cdf "Closed resistance" "1")
      tbSetCdf(cdf "Open resistance" "1T")
      tbSetCdf(cdf "Threshold 1" "0.4")
      tbSetCdf(cdf "Threshold 2" "0.6"))
    tbPin(cv swo "N+" "VOUT" 0.5 0.0)
    tbPin(cv swo "N-" "VSS" 0.5 -0.3)
    tbPin(cv swo "NC+" "RST" 0.5 -0.6)
    tbPin(cv swo "NC-" "VSS" 0.5 -0.9)
    tbPin(cv swx "N+" "VX" 0.5 0.0)
    tbPin(cv swx "N-" "VSS" 0.5 -0.3)
    tbPin(cv swx "NC+" "RST" 0.5 -0.6)
    tbPin(cv swx "NC-" "VSS" 0.5 -0.9)
    schCheck(cv)
    dbSave(cv)
    printf("buildCdacTB done: %s/%s\n" tbLib tbCell)
    cv))

printf("=== build_cdac_tb v3 loaded ===\n")
